simulator lang=spectre
global 0
parameters code

V7 (Dp\<7\> 0) vsource dc=1.8*(floor(code/128)-2*floor(code/256)) type=dc
V6 (Dp\<6\> 0) vsource dc=1.8*(floor(code/64)-2*floor(code/128)) type=dc
V5 (Dp\<5\> 0) vsource dc=1.8*(floor(code/32)-2*floor(code/64)) type=dc
V4 (Dp\<4\> 0) vsource dc=1.8*(floor(code/16)-2*floor(code/32)) type=dc
V3 (Dp\<3\> 0) vsource dc=1.8*(floor(code/8)-2*floor(code/16)) type=dc
V2 (Dp\<2\> 0) vsource dc=1.8*(floor(code/4)-2*floor(code/8)) type=dc
V1 (Dp\<1\> 0) vsource dc=1.8*(floor(code/2)-2*floor(code/4)) type=dc
V0 (Dp\<0\> 0) vsource dc=1.8*(floor(code/1)-2*floor(code/2)) type=dc
V15 (Dn\<7\> 0) vsource dc=1.8*(1-(floor(code/128)-2*floor(code/256))) \
        type=dc
V14 (Dn\<6\> 0) vsource dc=1.8*(1-(floor(code/64)-2*floor(code/128))) \
        type=dc
V13 (Dn\<5\> 0) vsource dc=1.8*(1-(floor(code/32)-2*floor(code/64))) \
        type=dc
V12 (Dn\<4\> 0) vsource dc=1.8*(1-(floor(code/16)-2*floor(code/32))) \
        type=dc
V11 (Dn\<3\> 0) vsource dc=1.8*(1-(floor(code/8)-2*floor(code/16))) \
        type=dc
V10 (Dn\<2\> 0) vsource dc=1.8*(1-(floor(code/4)-2*floor(code/8))) type=dc
V9 (Dn\<1\> 0) vsource dc=1.8*(1-(floor(code/2)-2*floor(code/4))) type=dc
V8 (Dn\<0\> 0) vsource dc=1.8*(1-(floor(code/1)-2*floor(code/2))) type=dc
simulatorOptions options psfversion="1.4.0" reltol=1e-3 vabstol=1e-6 \
    iabstol=1e-12 temp=27 tnom=27 scalem=1.0 scale=1.0 gmin=1e-12 rforce=1 \
    maxnotes=5 maxwarns=5 digits=5 cols=80 pivrel=1e-3 \
    sensfile="../psf/sens.output" checklimitdest=psf
modelParameter info what=models where=rawfile
element info what=inst where=rawfile
outputParameter info what=output where=rawfile
designParamVals info what=parameters where=rawfile
primitives info what=primitives where=rawfile
subckts info what=subckts where=rawfile
saveOptions options save=allpub
