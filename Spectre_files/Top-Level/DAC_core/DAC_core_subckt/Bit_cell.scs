simulator lang=spectre
global 0 vdd!
parameters weight

subckt Current_Steering_Switch Dn Dp OUTn OUTp S
parameters weight
    MswP (OUTp Dn S S) nch w=500n l=180n m=weight
    MswN (OUTn Dp S S) nch w=500n l=180n m=weight
ends Current_Steering_Switch

subckt Trim_DAC D TRIM Vb
parameters weight
    M3 (nTRIM TRIM vdd! vdd!) pch w=10u l=180.00n
    M2 (net1 nTRIM D D) pch w=4.5u l=180.00n m=2
    M5 (D TRIM net1 net1) nch w=4.5u l=180.00n m=1
    MT (net1 Vb 0 0) nch w=220n l=20u m=weight
    M4 (nTRIM TRIM 0 0) nch w=10u l=180.00n
ends Trim_DAC

subckt ADI_Project_6b_Trim_DAC_schematic Dt TRIM\<0\> TRIM\<1\> TRIM\<2\> \
        TRIM\<3\> TRIM\<4\> TRIM\<5\> Vb
parameters weight
    I5 (Dt TRIM\<5\> Vb) Trim_DAC weight=32*weight
    I4 (Dt TRIM\<4\> Vb) Trim_DAC weight=16*weight
    I3 (Dt TRIM\<3\> Vb) Trim_DAC weight=8*weight
    I2 (Dt TRIM\<2\> Vb) Trim_DAC weight=4*weight
    I1 (Dt TRIM\<1\> Vb) Trim_DAC weight=2*weight
    I0 (Dt TRIM\<0\> Vb) Trim_DAC weight=weight
ends ADI_Project_6b_Trim_DAC_schematic

subckt Current_Source D Vb
parameters weight
    Mcs (D Vb 0 0) nch w=1.183u l=500.0n m=weight
ends Current_Source

I6 (Dn Dp OUTn OUTp net2) Current_Steering_Switch weight=weight
I5 (net2 TRIM\<0\> TRIM\<1\> TRIM\<2\> TRIM\<3\> TRIM\<4\> TRIM\<5\> Vb) \
        ADI_Project_6b_Trim_DAC_schematic weight=weight
I2 (net2 Vb) Current_Source weight=weight
simulatorOptions options psfversion="1.4.0" reltol=1e-3 vabstol=1e-6 \
    iabstol=1e-12 temp=27 tnom=27 scalem=1.0 scale=1.0 gmin=1e-12 rforce=1 \
    maxnotes=5 maxwarns=5 digits=5 cols=80 pivrel=1e-3 \
    sensfile="../psf/sens.output" checklimitdest=psf
modelParameter info what=models where=rawfile
element info what=inst where=rawfile
outputParameter info what=output where=rawfile
designParamVals info what=parameters where=rawfile
primitives info what=primitives where=rawfile
subckts info what=subckts where=rawfile
saveOptions options save=allpub
