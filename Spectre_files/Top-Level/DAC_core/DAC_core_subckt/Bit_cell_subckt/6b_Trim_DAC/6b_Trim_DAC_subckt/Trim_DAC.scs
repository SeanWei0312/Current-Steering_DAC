simulator lang=spectre
global 0 vdd!
parameters weight

M3 (nTRIM TRIM vdd! vdd!) pch w=10u l=180.00n
M2 (net1 nTRIM D D) pch w=4.5u l=180.00n m=2
M5 (D TRIM net1 net1) nch w=4.5u l=180.00n m=1
MT (net1 Vb 0 0) nch w=220n l=20u m=weight
M4 (nTRIM TRIM 0 0) nch w=10u l=180.00n
simulatorOptions options psfversion="1.4.0" reltol=1e-3 vabstol=1e-6 \
    iabstol=1e-12 temp=27 tnom=27 scalem=1.0 scale=1.0 gmin=1e-12 rforce=1 \
    maxnotes=5 maxwarns=5 digits=5 cols=80 pivrel=1e-3 \
    sensfile="../psf/sens.output" checklimitdest=psf
modelParameter info what=models where=rawfile
element info what=inst where=rawfile
outputParameter info what=output where=rawfile
designParamVals info what=parameters where=rawfile
primitives info what=primitives where=rawfile
subckts info what=subckts where=rawfile
saveOptions options save=allpub
