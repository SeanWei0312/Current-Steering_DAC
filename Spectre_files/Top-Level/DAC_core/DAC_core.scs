simulator lang=spectre
global 0 vdd!

subckt Current_Steering_Switch Dn Dp OUTn OUTp S
parameters weight
    MswP (OUTp Dn S S) nch w=500n l=180n m=weight
    MswN (OUTn Dp S S) nch w=500n l=180n m=weight
ends Current_Steering_Switch

subckt Trim_DAC D TRIM Vb
parameters weight
    M3 (nTRIM TRIM vdd! vdd!) pch w=10u l=180.00n
    M2 (net1 nTRIM D D) pch w=4.5u l=180.00n m=2
    M5 (D TRIM net1 net1) nch w=4.5u l=180.00n m=1
    MT (net1 Vb 0 0) nch w=220n l=20u m=weight
    M4 (nTRIM TRIM 0 0) nch w=10u l=180.00n
ends Trim_DAC

subckt ADI_Project_6b_Trim_DAC_schematic Dt TRIM\<0\> TRIM\<1\> TRIM\<2\> \
        TRIM\<3\> TRIM\<4\> TRIM\<5\> Vb
parameters weight
    I5 (Dt TRIM\<5\> Vb) Trim_DAC weight=32*weight
    I4 (Dt TRIM\<4\> Vb) Trim_DAC weight=16*weight
    I3 (Dt TRIM\<3\> Vb) Trim_DAC weight=8*weight
    I2 (Dt TRIM\<2\> Vb) Trim_DAC weight=4*weight
    I1 (Dt TRIM\<1\> Vb) Trim_DAC weight=2*weight
    I0 (Dt TRIM\<0\> Vb) Trim_DAC weight=weight
ends ADI_Project_6b_Trim_DAC_schematic

subckt Current_Source D Vb
parameters weight
    Mcs (D Vb 0 0) nch w=1.183u l=500.0n m=weight
ends Current_Source

subckt Bit_cell Dn Dp OUTn OUTp TRIM\<0\> TRIM\<1\> TRIM\<2\> TRIM\<3\> \
        TRIM\<4\> TRIM\<5\> Vb
parameters weight
    I6 (Dn Dp OUTn OUTp net2) Current_Steering_Switch weight=weight
    I5 (net2 TRIM\<0\> TRIM\<1\> TRIM\<2\> TRIM\<3\> TRIM\<4\> TRIM\<5\> \
        Vb) ADI_Project_6b_Trim_DAC_schematic weight=weight
    I2 (net2 Vb) Current_Source weight=weight
ends Bit_cell

IBIT_cell_6 (Dn\<6\> Dp\<6\> OUTn OUTp T6\<0\> T6\<1\> T6\<2\> T6\<3\> \
        T6\<4\> T6\<5\> Vb) Bit_cell weight=64
IBIT_cell_5 (Dn\<5\> Dp\<5\> OUTn OUTp T5\<0\> T5\<1\> T5\<2\> T5\<3\> \
        T5\<4\> T5\<5\> Vb) Bit_cell weight=32
IBIT_cell_4 (Dn\<4\> Dp\<4\> OUTn OUTp T4\<0\> T4\<1\> T4\<2\> T4\<3\> \
        T4\<4\> T4\<5\> Vb) Bit_cell weight=16
IBIT_cell_3 (Dn\<3\> Dp\<3\> OUTn OUTp T3\<0\> T3\<1\> T3\<2\> T3\<3\> \
        T3\<4\> T3\<5\> Vb) Bit_cell weight=8
IBIT_cell_2 (Dn\<2\> Dp\<2\> OUTn OUTp T2\<0\> T2\<1\> T2\<2\> T2\<3\> \
        T2\<4\> T2\<5\> Vb) Bit_cell weight=4
IBIT_cell_1 (Dn\<1\> Dp\<1\> OUTn OUTp T1\<0\> T1\<1\> T1\<2\> T1\<3\> \
        T1\<4\> T1\<5\> Vb) Bit_cell weight=2
IBIT_cell_7 (Dn\<7\> Dp\<7\> OUTn OUTp T7\<0\> T7\<1\> T7\<2\> T7\<3\> \
        T7\<4\> T7\<5\> Vb) Bit_cell weight=128
IBIT_cell_0 (Dn\<0\> Dp\<0\> OUTn OUTp T0\<0\> T0\<1\> T0\<2\> T0\<3\> \
        T0\<4\> T0\<5\> Vb) Bit_cell weight=1
simulatorOptions options psfversion="1.4.0" reltol=1e-3 vabstol=1e-6 \
    iabstol=1e-12 temp=27 tnom=27 scalem=1.0 scale=1.0 gmin=1e-12 rforce=1 \
    maxnotes=5 maxwarns=5 digits=5 cols=80 pivrel=1e-3 \
    sensfile="../psf/sens.output" checklimitdest=psf
modelParameter info what=models where=rawfile
element info what=inst where=rawfile
outputParameter info what=output where=rawfile
designParamVals info what=parameters where=rawfile
primitives info what=primitives where=rawfile
subckts info what=subckts where=rawfile
saveOptions options save=allpub
